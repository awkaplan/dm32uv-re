// st7789v_madctl.rdl - the one LCD-controller register this repo models in SystemRDL: MADCTL,
// MIPI DCS set_address_mode (command 0x36), one 8-bit parameter. The rest of the panel's command
// set is a list of opcodes, not registers: tools/include/mipi_dcs.h (standard) and
// tools/include/st7789v.h (vendor). The stock init sequence: specs/lcd/st7789v_stock_init.txt.
//
// WHICH CONTROLLER. The stock init's vendor commands match the Sitronix ST7789V (specs/lcd/
// README.md); genuine part or compatible clone is unconfirmed. The repo previously called the
// controller "HX8353E" (Himax); MADCTL has the same bit positions on both, with two bits named
// differently (ST7789V RGB/MH = HX8353E BGR/SS), so the HX8353E section is cited as a cross-check.
//
// SOURCES.
//   [ST] Sitronix ST7789V datasheet Version 1.3, 2014/03, 9.1.28 MADCTL (36h), p.215-217; 9.2.10
//        LCMCTRL (C0h), p.275 (PDF page = printed page).
//   [HX] Himax HX8353-E datasheet V01 (v0.1), April 2012, 8.2.29 Memory access control (36h),
//        p.149-150.
//   [FW] stock DM32.00.01.048: lcd_set_orientation @0x030178ec writes command 0x36 then 0xC0 if
//        its argument is 0, else 0x00 (disassembly). Callers: the panel init
//        lcd_controller_power_on_init_sequence @0x03017d4c (call at 0x03017df8, argument = bit 0 of
//        settings byte IRAM 0x0003e9b4 + 0x6d) and the display-direction menu handler @0x0304fdf8,
//        which stores the new choice into that same bit first (option list @0x0304478c).
//   [QEMU] stock boot under -M dm32 with breakpoints on lcd_write_command/lcd_write_data (gdb stub,
//        2026-10-11): argument 0, wire bytes `36` then `c0`.

`include "dm32_udp.rdl"

addrmap st7789v_madctl {
    name = "ST7789V MADCTL (36h)";
    desc = "MIPI DCS set_address_mode. Written as command byte 0x36 (i8080 command port 0x12000000) followed by one parameter byte (data port 0x12000004). The address here is only a placeholder; wire_addr is the command opcode.";
    ds_ref = "ST7789V v1.3, 9.1.28, p.215-217; HX8353-E V01, 8.2.29, p.149-150";
    confidence = "CONFIRMED";
    default regwidth = 8;
    default accesswidth = 8;
    default sw = w;
    default hw = r;

    reg {
        name = "MADCTL";
        desc = "Memory data access control: frame-memory read/write scan direction and the RGB/BGR order. Stock writes 0xC0 (MY|MX: rows and columns both reversed, i.e. the frame rotated 180 degrees, RGB order) when the user's display-direction setting bit is 0 (the default on a blank configuration), and 0x00 when it is 1. Default 00h after power-on and H/W reset, unchanged by S/W reset (HX8353E p.150; ST7789V p.217). Read back with RDDMADCTL (0Bh). CAUTION: LCMCTRL (C0h) parameter XORs MY, BGR, MX, MV and others into this register; stock writes C0h = 0x2C (= the ST7789V default), whose set bits are XBGR, XMX and XMV (ST7789V 9.2.10, p.275). How that combines with this value on the real panel has not been measured.";
        ds_ref = "ST7789V v1.3, 9.1.28 p.215-217, 9.2.10 p.275; HX8353-E V01, 8.2.29, p.149-150";
        ds_value = "00h (power-on and H/W reset), no change on S/W reset";
        fw_writes = "0x030178ec lcd_set_orientation: 0xC0 (argument 0) or 0x00 (argument != 0); called from 0x03017df8 (panel init) and 0x0304fdf8 (display-direction menu)";
        hw_reads = "QEMU, stock boot: 36 c0";
        confidence = "CONFIRMED";
        wire_addr = 0x36;
        field {
            name = "MY";
            desc = "Page (row) address order: 0 = top to bottom, 1 = bottom to top. See HX8353E 6.2.1 / ST7789V 8.12 for the MCU-to-memory direction tables. Stock: 1 (direction setting 0) or 0.";
            ds_ref = "ST7789V v1.3, 9.1.28, p.215; HX8353-E V01, 8.2.29, p.149";
            fw_writes = "1 / 0 (0x030178ec)";
            hw_reads = "QEMU, stock boot: 1";
            confidence = "CONFIRMED";
        } my[7:7] = 0;
        field {
            name = "MX";
            desc = "Column address order: 0 = left to right, 1 = right to left. Stock: 1 (direction setting 0) or 0.";
            ds_ref = "ST7789V v1.3, 9.1.28, p.215; HX8353-E V01, 8.2.29, p.149";
            fw_writes = "1 / 0 (0x030178ec)";
            hw_reads = "QEMU, stock boot: 1";
            confidence = "CONFIRMED";
        } mx[6:6] = 0;
        field {
            name = "MV";
            desc = "Page/column exchange (row/column swap): 0 = normal, 1 = reverse. Stock: 0 (never swaps; the frame is always addressed 240 wide x 320 tall).";
            ds_ref = "ST7789V v1.3, 9.1.28, p.215; HX8353-E V01, 8.2.29, p.149";
            fw_writes = "0";
            confidence = "CONFIRMED";
        } mv[5:5] = 0;
        field {
            name = "ML";
            desc = "Vertical (line) refresh order of the panel: 0 = top to bottom, 1 = bottom to top. Affects refresh, not memory addressing. Stock: 0.";
            ds_ref = "ST7789V v1.3, 9.1.28, p.215; HX8353-E V01, 8.2.29, p.149";
            fw_writes = "0";
            confidence = "CONFIRMED";
        } ml[4:4] = 0;
        field {
            name = "RGB";
            desc = "RGB/BGR order: 0 = RGB, 1 = BGR. HX8353E names this bit BGR (same position, same meaning). LCMCTRL XBGR XORs it. Stock: 0.";
            ds_ref = "ST7789V v1.3, 9.1.28, p.215; HX8353-E V01, 8.2.29, p.149";
            fw_writes = "0";
            confidence = "CONFIRMED";
        } rgb[3:3] = 0;
        field {
            name = "MH";
            desc = "Display data latch order (horizontal refresh): 0 = LCD refresh left to right, 1 = right to left. HX8353E names this bit SS, horizontal order (same position). Stock: 0.";
            ds_ref = "ST7789V v1.3, 9.1.28, p.215; HX8353-E V01, 8.2.29, p.149-150";
            fw_writes = "0";
            confidence = "CONFIRMED";
        } mh[2:2] = 0;
        field {
            name = "RSVD";
            desc = "Unused (shown as '-'; HX8353E sets D1:D0 to 00 internally). Stock: 0.";
            ds_ref = "ST7789V v1.3, 9.1.28, p.215; HX8353-E V01, 8.2.29, p.150";
            fw_writes = "0";
            confidence = "CONFIRMED";
        } rsvd[1:0] = 0;
    } madctl @ 0x0;
};
